** Profile: "SCHEMATIC1-simu"  [ C:\Users\Bertan\Desktop\Rapor 4\o.c.4-SCHEMATIC1-simu.sim ]

** Creating circuit file "o.c.4-SCHEMATIC1-simu.sim.cir"
** WARNING: THIS AUTOMATICALLY GENERATED FILE MAY BE OVERWRITTEN BY SUBSEQUENT SIMULATIONS

*Libraries:
* Local Libraries :
* From [PSPICE NETLIST] section of C:\Program Files\OrcadLite\PSpice\PSpice.ini file:
.lib "D:\DERSLER\5.YARIYIL\EEM 311 LAB\deney 4\deney4\jfet.lib"
.lib "D:\DERSLER\5.YARIYIL\EEM 311 LAB\deney 4\deney4\jfet.lib"
.lib "D:\DERSLER\5.YARIYIL\EEM 311 LAB\deney 3\deney3\cd4007.lib"
.lib "nom.lib"

*Analysis directives:
.TRAN  0 5ms 0
.PROBE V(*) I(*) W(*) D(*) NOISE(*)
.INC ".\o.c.4-SCHEMATIC1.net"

.END
